# Ansys Electronics Desktop project, version 2024.2
materials:
  vacuum: permittivity=1
  M250_35A: permeability{HUnit=A_per_meter BUnit=tesla curve (0, 0) (26.8, 0.1) (35.7, 0.2) (41.8, 0.3) (47.5, 0.4) (53.4, 0.5) (60, 0.6) (67.9, 0.7) (77.5, 0.8) (90, 0.9) (107, 1) (133, 1.1) (179, 1.2) (284, 1.3) (642, 1.4) (1810, 1.5) (4030, 1.6) (7290, 1.7) (11700, 1.8) (100000, 1.97)} stacking_type=Lamination stacking_factor=0.95 stacking_direction=V(3)
  N42SH: permeability=1.05 magnetic_coercivity{Magnitude=-897143A_per_meter DirComp1=0 DirComp2=1 DirComp3=0}
  copper: permeability=0.999991 conductivity=58000000
  N42SH_Neg: permeability=1.05 magnetic_coercivity{Magnitude=-897143A_per_meter DirComp1=0 DirComp2=-1 DirComp3=0}

design Maxwell2DDesign1 (Maxwell 2D, Magnetostatic, XY geometry, model units mm)
options: ModelDepth=StackLength
variables:
  InitAngle = 0deg
  nC = 4
  CD = 10*1e6
  Magnet_MeshLength = 2mm
  StackLength = 70mm
  EdgeMove = -0.1mm
  Pole_Angle = 22deg
  theta_1 = 32.5deg
  theta_2 = (32.5 + 70) deg
  phase_delay = -30deg
geometry:
  coordinate_system RelativeCS1 = origin=(0mm, 0mm, 0mm) x=(cos(-pole_angle + theta_1), -sin(-pole_angle + theta_1), 0mm) y=(cos(-(pole_angle+90deg) + theta_1), -sin(-(pole_angle +90deg) + theta_1), 0mm)
  Magnet_1 [N42SH, oriented by RelativeCS1] = imported_body(C:/Users/ssankar/AppData/Local/Temp/089811941217788821021..x_t)
  coordinate_system RelativeCS9 = origin=(0mm, 0mm, 0mm) x=(cos(-pole_angle + theta_2), -sin(-pole_angle + theta_2), 0mm) y=(cos(-(pole_angle+90deg) + theta_2), -sin(-(pole_angle+90deg) + theta_2), 0mm)
  Magnet_2 [N42SH, oriented by RelativeCS9] = imported_body(C:/Users/ssankar/AppData/Local/Temp/089811941217788821021..x_t)
  PhaseA_1 [copper] = imported_body(C:/Users/ssankar/AppData/Local/Temp/091A11941217788821424..x_t)
  PhaseC_1, PhaseB_1 [copper] = PhaseA_1.duplicate_around_axis(axis=Z, angle=(120/8) deg, total=3)
  PhaseA_2 [copper] = imported_body(C:/Users/ssankar/AppData/Local/Temp/091A11941217788821424..x_t)
  PhaseC_2, PhaseB_2 [copper] = PhaseA_2.duplicate_around_axis(axis=Z, angle=(120/8) deg, total=3)
  PhaseA_3 [copper] = imported_body(C:/Users/ssankar/AppData/Local/Temp/091A11941217788821424..x_t)
  PhaseC_3, PhaseB_3 [copper] = PhaseA_3.duplicate_around_axis(axis=Z, angle=(120/8) deg, total=3)
  PhaseA_4 [copper] = imported_body(C:/Users/ssankar/AppData/Local/Temp/091A11941217788821424..x_t)
  PhaseC_4, PhaseB_4 [copper] = PhaseA_4.duplicate_around_axis(axis=Z, angle=(120/8) deg, total=3)
  Stator_core_1_57 = imported_body(C:/Users/ssankar/AppData/Local/Temp/091A11941217788821424..x_t)
  Stator_core_1_57_2 [M250_35A, non-model], Stator_core_1_57_1 = Stator_core_1_57.duplicate_around_axis(axis=Z, angle=(120/8) deg, total=3)
  Stator_core_1_57_2.unite(Stator_core_1_57_1, Stator_core_1_57)
  Magnet_2.move_edges(MoveAlongNormalFlag=true OffsetDistance=-0.1mm EdgesToMove=?.edge(at (21.4753, 16.6189, 0)))
  Magnet_2.move_edges(MoveAlongNormalFlag=true OffsetDistance=-0.1mm EdgesToMove=?.edge(at (24.4042, 15.9696, 0)))
  Magnet_2.move_edges(MoveAlongNormalFlag=true OffsetDistance=-0.1mm EdgesToMove=?.edge(at (24.1301, 21.6639, 0)))
  Magnet_2.move_edges(MoveAlongNormalFlag=true OffsetDistance=-0.1mm EdgesToMove=?.edge(at (21.7493, 10.9246, 0)))
  Magnet_1.move_edges(MoveAlongNormalFlag=true OffsetDistance=-0.1mm EdgesToMove=?.edge(at (28.5486, 5.96414, 0)))
  Magnet_1.move_edges(MoveAlongNormalFlag=true OffsetDistance=EdgeMove EdgesToMove=?.edge(at (32.3544, 1.70173, 0)))
  Magnet_1.move_edges(MoveAlongNormalFlag=true OffsetDistance=EdgeMove EdgesToMove=?.edge(at (26.8945, 3.46083, 0)))
  Magnet_1.move_edges(MoveAlongNormalFlag=true OffsetDistance=EdgeMove EdgesToMove=?.edge(at (23.104, 7.6542, 0)))
  Circle3 = circle(normal=Z, centre=(0mm, 0mm, 0mm), radius=58mm)
  Circle4 = circle(normal=Z, centre=(0mm, 0mm, 0mm), radius=56mm)
  Circle3.subtract(Circle4)
  Circle3.split(plane=ZX, keep=PositiveOnly)
  Circle3.rotate(axis=Z, angle=-135deg)
  Circle3.split(plane=ZX, keep=PositiveOnly)
  Stator_core_1_57_2.unite(Circle3)
  Stator1, Stator3 [M250_35A, non-model] = imported_body()
  Stator2, Rotor [M250_35A] = imported_body()
  Region [vacuum] = polyline((0mm, 0mm, 0mm) (43.84062mm, 43.84062mm, 0mm))
  Polyline3 = polyline(z=0mm, xy in mm: (62, 0) (57.280531, 23.726373) (43.84062, 43.84062), AngularArc from point 0 over 3 centre=(0mm, 0mm, 0mm) angle=45deg plane=XY)
  Polyline4 = polyline((0mm, 0mm, 0mm) (62mm, 0mm, 0mm))
  Region.unite(Polyline3, Polyline4)
  Region.cover_lines()
  Rotor_1..Rotor_7 = Rotor.duplicate_around_axis(axis=Z, angle=45deg, total=8)
  Rotor.unite(Rotor_1..Rotor_7)
  Magnet_1_1 [N42SH, oriented by RelativeCS2], Magnet_1_2 [N42SH, oriented by RelativeCS3], Magnet_1_3 [N42SH, oriented by RelativeCS4], Magnet_1_4 [N42SH, oriented by RelativeCS5], Magnet_1_5 [N42SH, oriented by RelativeCS6], Magnet_1_6 [N42SH, oriented by RelativeCS7], Magnet_1_7 [N42SH, oriented by RelativeCS8] = Magnet_1.duplicate_around_axis(axis=Z, angle=45deg, total=8)
  coordinate_system RelativeCS2 = origin=(0mm, 0mm, 0mm) x=(cos(-pole_angle + theta_1 - 45deg), -sin(-pole_angle + theta_1 - 45deg), 0mm) y=(cos(-(pole_angle +90deg) + theta_1 - 45deg), -sin(-(pole_angle+90deg) + theta_1 - 45deg), 0mm)
  coordinate_system RelativeCS3 = origin=(0mm, 0mm, 0mm) x=(cos(-pole_angle + theta_1 - 90deg), -sin(-pole_angle + theta_1 - 90deg), 0mm) y=(cos(-(pole_angle+90deg) + theta_1 - 90deg), -sin(-(pole_angle+90deg) + theta_1 - 90deg), 0mm)
  coordinate_system RelativeCS4 = origin=(0mm, 0mm, 0mm) x=(cos(-pole_angle + theta_1 - 135deg), -sin(-pole_angle + theta_1 - 135deg), 0mm) y=(cos(-(pole_angle+90deg) + theta_1 - 135deg), -sin(-(pole_angle+90deg) + theta_1 - 135deg), 0mm)
  coordinate_system RelativeCS5 = origin=(0mm, 0mm, 0mm) x=(cos(-pole_angle + theta_1 - 180deg), -sin(-pole_angle + theta_1 - 180deg), 0mm) y=(cos(-(pole_angle+90deg) + theta_1 - 180deg), -sin(-(pole_angle+90deg) + theta_1 - 180deg), 0mm)
  coordinate_system RelativeCS6 = origin=(0mm, 0mm, 0mm) x=(cos(-pole_angle + theta_1 - 225deg), -sin(-pole_angle + theta_1 - 225deg), 0mm) y=(cos(-(pole_angle+90deg) + theta_1 - 225deg), -sin(-(pole_angle+90deg) + theta_1 - 225deg), 0mm)
  coordinate_system RelativeCS7 = origin=(0mm, 0mm, 0mm) x=(cos(-pole_angle + theta_1 - 270deg), -sin(-pole_angle + theta_1 - 270deg), 0mm) y=(cos(-(pole_angle+90deg) + theta_1 - 270deg), -sin(-(pole_angle+90deg) + theta_1 - 270deg), 0mm)
  coordinate_system RelativeCS8 = origin=(0mm, 0mm, 0mm) x=(cos(-pole_angle + theta_1 - 315deg), -sin(-pole_angle + theta_1 - 315deg), 0mm) y=(cos(-(pole_angle+90deg) + theta_1 - 315deg), -sin(-(pole_angle+90deg) + theta_1 - 315deg), 0mm)
  Magnet_2_1 [N42SH, oriented by RelativeCS16], Magnet_2_2 [N42SH, oriented by RelativeCS15], Magnet_2_3 [N42SH, oriented by RelativeCS14], Magnet_2_4 [N42SH, oriented by RelativeCS13], Magnet_2_5 [N42SH, oriented by RelativeCS12], Magnet_2_6 [N42SH, oriented by RelativeCS11], Magnet_2_7 [N42SH, oriented by RelativeCS10] = Magnet_2.duplicate_around_axis(axis=Z, angle=45deg, total=8)
  coordinate_system RelativeCS16 = origin=(0mm, 0mm, 0mm) x=(cos(-pole_angle + theta_2 + 315deg), -sin(-pole_angle + theta_2 + 315deg), 0mm) y=(cos(-(pole_angle+90deg) + theta_2 + 315deg), -sin(-(pole_angle+90deg) + theta_2 + 315deg), 0mm)
  coordinate_system RelativeCS15 = origin=(0mm, 0mm, 0mm) x=(cos(-pole_angle + theta_2 + 270deg), -sin(-pole_angle + theta_2 + 270deg), 0mm) y=(cos(-(pole_angle+90deg) + theta_2 + 270deg), -sin(-(pole_angle+90deg) + theta_2 + 270deg), 0mm)
  coordinate_system RelativeCS14 = origin=(0mm, 0mm, 0mm) x=(cos(-pole_angle + theta_2 + 225deg), -sin(-pole_angle + theta_2 + 225deg), 0mm) y=(cos(-(pole_angle+90deg) + theta_2 + 225deg), -sin(-(pole_angle+90deg) + theta_2 + 225deg), 0mm)
  coordinate_system RelativeCS13 = origin=(0mm, 0mm, 0mm) x=(cos(-pole_angle + theta_2 + 180deg), -sin(-pole_angle + theta_2 + 180deg), 0mm) y=(cos(-(pole_angle+90deg) + theta_2 + 180deg), -sin(-(pole_angle+90deg) + theta_2 + 180deg), 0mm)
  coordinate_system RelativeCS12 = origin=(0mm, 0mm, 0mm) x=(cos(-pole_angle + theta_2 + 135deg), -sin(-pole_angle + theta_2 + 135deg), 0mm) y=(cos(-(pole_angle+90deg) + theta_2 + 135deg), -sin(-(pole_angle+90deg) + theta_2 + 135deg), 0mm)
  coordinate_system RelativeCS11 = origin=(0mm, 0mm, 0mm) x=(cos(-pole_angle + theta_2 + 90deg), -sin(-pole_angle + theta_2 + 90deg), 0mm) y=(cos(-(pole_angle+90deg) + theta_2 + 90deg), -sin(-(pole_angle+90deg) + theta_2 + 90deg), 0mm)
  coordinate_system RelativeCS10 = origin=(0mm, 0mm, 0mm) x=(cos(-pole_angle + theta_2 + 45deg), -sin(-pole_angle + theta_2 + 45deg), 0mm) y=(cos(-(pole_angle+90deg) + theta_2 + 45deg), -sin(-(pole_angle+90deg) + theta_2 + 45deg), 0mm)
  [Magnet_1, Magnet_1_1..Magnet_1_7, Magnet_2, Magnet_2_1..Magnet_2_7, Rotor].rotate(axis=Z, angle=initAngle)
  [Magnet_1, Magnet_1_1..Magnet_1_7, Magnet_2, Magnet_2_1..Magnet_2_7, Rotor].rotate(axis=Z, angle=Pole_Angle)
  Rectangle1 = rectangle(corner=(-50mm, 0mm, 0mm), x_size=100mm, y_size=-40mm)
  coordinate_system RelativeCS_45deg = origin=(0mm, 0mm, 0mm) x=(1mm, 1mm, 0mm) y=(0mm, 1mm, 0mm)
  Rectangle2 = rectangle(corner=(-50mm, 0mm, 0mm), x_size=100mm, y_size=45mm) in RelativeCS_45deg
  Rectangle1_1 = Rectangle1.copy()
  Rectangle2_1 = Rectangle2.copy()
  Magnet_1.subtract(Rectangle1_1, Rectangle2_1)
  Rectangle1.unite(Rectangle2)
  Rectangle1_10 = Rectangle1.copy()
  Magnet_1.subtract(Rectangle1_10)
  Rectangle1_11 = Rectangle1.copy()
  Magnet_1.subtract(Rectangle1_11)
  Rectangle1_12 = Rectangle1.copy()
  Magnet_1_1.subtract(Rectangle1_12)
  Rectangle1_13 = Rectangle1.copy()
  Magnet_1_2.subtract(Rectangle1_13)
  Rectangle1_14 = Rectangle1.copy()
  Magnet_1_3.subtract(Rectangle1_14)
  Rectangle1_15 = Rectangle1.copy()
  Magnet_1_4.subtract(Rectangle1_15)
  Rectangle1_16 = Rectangle1.copy()
  Magnet_1_5.subtract(Rectangle1_16)
  Rectangle1_17 = Rectangle1.copy()
  Magnet_1_6.subtract(Rectangle1_17)
  Rectangle1_18 = Rectangle1.copy()
  Magnet_1_7.subtract(Rectangle1_18)
  Rectangle1_19 = Rectangle1.copy()
  Magnet_2.subtract(Rectangle1_19)
  Rectangle1_20 = Rectangle1.copy()
  Magnet_2_1.subtract(Rectangle1_20)
  Rectangle1_21 = Rectangle1.copy()
  Magnet_2_2.subtract(Rectangle1_21)
  Rectangle1_22 = Rectangle1.copy()
  Magnet_2_3.subtract(Rectangle1_22)
  Rectangle1_23 = Rectangle1.copy()
  Magnet_2_4.subtract(Rectangle1_23)
  Rectangle1_24 = Rectangle1.copy()
  Magnet_2_5.subtract(Rectangle1_24)
  Rectangle1_25 = Rectangle1.copy()
  Magnet_2_6.subtract(Rectangle1_25)
  Rectangle1_26 = Rectangle1.copy()
  Magnet_2_7.subtract(Rectangle1_26)
  Rotor.subtract(Rectangle1)
  Band [vacuum] = circle(normal=Z, centre=(0mm, 0mm, 0mm), radius=(34.96 + 0.5) mm)
  Band.split(plane=ZX, keep=PositiveOnly)
  Band.rotate(axis=Z, angle=-45deg)
  Band.split(plane=ZX, keep=NegativeOnly)
  Band.rotate(axis=Z, angle=45deg)
boundaries and excitations:
  Balloon1: Balloon Edges=Region.edge(at (57.2805, 23.7264, 0))
  Independent1: Independent Edges=Region.edge(at (31, 0, 0))
  Dependent1: Dependent Edges=Region.edge(at (21.9203, 21.9203, 0)) Independent=Independent1 SameAsMaster=false
  CurrentDensity1: Current Density Objects=PhaseA_1 Value=CD*cos(phase_delay)
  CurrentDensity2: Current Density Objects=PhaseA_2 Value=CD*cos(phase_delay)
  CurrentDensity3: Current Density Objects=PhaseA_3 Value=CD*cos(phase_delay)
  CurrentDensity4: Current Density Objects=PhaseA_4 Value=CD*cos(phase_delay)
  CurrentDensity5: Current Density Objects=PhaseB_1 Value="1*CD*cos(phase_delay - 120deg)"
  CurrentDensity6: Current Density Objects=PhaseB_2 Value="1*CD*cos(phase_delay - 120deg)"
  CurrentDensity7: Current Density Objects=PhaseB_3 Value="1*CD*cos(phase_delay - 120deg)"
  CurrentDensity8: Current Density Objects=PhaseB_4 Value="1*CD*cos(phase_delay - 120deg)"
  CurrentDensity9: Current Density Objects=PhaseC_1 Value="-1*CD*cos(phase_delay - 240deg)"
  CurrentDensity10: Current Density Objects=PhaseC_2 Value="-1*CD*cos(phase_delay - 240deg)"
  CurrentDensity11: Current Density Objects=PhaseC_3 Value="-1*CD*cos(phase_delay - 240deg)"
  CurrentDensity12: Current Density Objects=PhaseC_4 Value="-1*CD*cos(phase_delay - 240deg)"
parameters:
  Torque_Rotor: Torque Coordinate_System=Global Is_Positive=true Objects=[Magnet_2, Magnet_1_1..Magnet_1_6, Magnet_2_1..Magnet_2_6, Magnet_1, Magnet_1_7, Magnet_2_7, Rotor]
  Torque_StatorCore: Torque Coordinate_System=Global Is_Positive=true Objects=Stator2
  Torque_RotorCore: Torque Coordinate_System=Global Is_Positive=true Objects=Rotor
  Torque_Stator: Torque Coordinate_System=Global Is_Positive=true Objects=[PhaseA_1..PhaseA_4, PhaseB_1..PhaseB_4, PhaseC_1..PhaseC_4, Stator2]
  Torque_Rotor_Band: Torque Coordinate_System=Global Is_Positive=true Objects=[Magnet_1_1..Magnet_1_7, Magnet_2_1..Magnet_2_7, Band, Magnet_1, Magnet_2, Rotor]
  Torque_magnets: Torque Coordinate_System=Global Is_Positive=true Objects=[Magnet_1_1..Magnet_1_7, Magnet_2_1..Magnet_2_7, Magnet_1, Magnet_2]
setups:
  Setup1: Magnetostatic MaximumPasses=10 MinimumPasses=2 MinimumConvergedPasses=1 PercentRefinement=30 PercentError=1 NonLinearResidual=0.0001
optimetrics:
  ParametricSetup1: Parametric Sim._Setups=[Setup1]
    sweep Pole_Angle: LIN 0deg 45deg 1deg
field plots:
  Mesh1: MeshPlots on Setup1 : LastAdaptive
  Flux_Lines1: A over Rotor, Stator2, Magnet_1, Magnet_1_7, Magnet_2_7, Region on Setup1 : LastAdaptive
  Mag_B1: B on Setup1 : LastAdaptive
reports:
  Torque Plot 1: 8*Torque_Rotor.Torque, 8*Torque_RotorCore.Torque, 8*Torque_Stator.Torque, 8*Torque_StatorCore.Torque, 8*Torque_Rotor_Band.Torque, 8*Torque_magnets.Torque, 8*(Torque_magnets.Torque + Torque_RotorCore.Torque) vs Pole_Angle on Setup1 : LastAdaptive

design Maxwell2DDesign2_NoMagnet (Maxwell 2D, Magnetostatic, XY geometry, model units mm)
options: ModelDepth=StackLength
variables:
  InitAngle = 0deg
  nC = 4
  CD = 10*1e6
  Magnet_MeshLength = 2mm
  StackLength = 70mm
  EdgeMove = -0.1mm
  Pole_Angle = 0deg
  theta_1 = 32.5deg
  theta_2 = (32.5 + 70) deg
  phase_delay = -30deg
geometry:
  coordinate_system RelativeCS1 = origin=(0mm, 0mm, 0mm) x=(cos(-pole_angle + theta_1), -sin(-pole_angle + theta_1), 0mm) y=(cos(-(pole_angle+90deg) + theta_1), -sin(-(pole_angle +90deg) + theta_1), 0mm)
  Magnet_1 [N42SH, non-model, oriented by RelativeCS1] = imported_body(C:/Users/ssankar/AppData/Local/Temp/089811941217788821021..x_t)
  coordinate_system RelativeCS9 = origin=(0mm, 0mm, 0mm) x=(cos(-pole_angle + theta_2), -sin(-pole_angle + theta_2), 0mm) y=(cos(-(pole_angle+90deg) + theta_2), -sin(-(pole_angle+90deg) + theta_2), 0mm)
  Magnet_2 [N42SH, non-model, oriented by RelativeCS9] = imported_body(C:/Users/ssankar/AppData/Local/Temp/089811941217788821021..x_t)
  PhaseA_1 [copper] = imported_body(C:/Users/ssankar/AppData/Local/Temp/091A11941217788821424..x_t)
  PhaseC_1, PhaseB_1 [copper] = PhaseA_1.duplicate_around_axis(axis=Z, angle=(120/8) deg, total=3)
  PhaseA_2 [copper] = imported_body(C:/Users/ssankar/AppData/Local/Temp/091A11941217788821424..x_t)
  PhaseC_2, PhaseB_2 [copper] = PhaseA_2.duplicate_around_axis(axis=Z, angle=(120/8) deg, total=3)
  PhaseA_3 [copper] = imported_body(C:/Users/ssankar/AppData/Local/Temp/091A11941217788821424..x_t)
  PhaseC_3, PhaseB_3 [copper] = PhaseA_3.duplicate_around_axis(axis=Z, angle=(120/8) deg, total=3)
  PhaseA_4 [copper] = imported_body(C:/Users/ssankar/AppData/Local/Temp/091A11941217788821424..x_t)
  PhaseC_4, PhaseB_4 [copper] = PhaseA_4.duplicate_around_axis(axis=Z, angle=(120/8) deg, total=3)
  Stator_core_1_57 = imported_body(C:/Users/ssankar/AppData/Local/Temp/091A11941217788821424..x_t)
  Stator_core_1_57_2 [M250_35A, non-model], Stator_core_1_57_1 = Stator_core_1_57.duplicate_around_axis(axis=Z, angle=(120/8) deg, total=3)
  Stator_core_1_57_2.unite(Stator_core_1_57_1, Stator_core_1_57)
  Magnet_2.move_edges(MoveAlongNormalFlag=true OffsetDistance=-0.1mm EdgesToMove=?.edge(at (21.4753, 16.6189, 0)))
  Magnet_2.move_edges(MoveAlongNormalFlag=true OffsetDistance=-0.1mm EdgesToMove=?.edge(at (24.4042, 15.9696, 0)))
  Magnet_2.move_edges(MoveAlongNormalFlag=true OffsetDistance=-0.1mm EdgesToMove=?.edge(at (24.1301, 21.6639, 0)))
  Magnet_2.move_edges(MoveAlongNormalFlag=true OffsetDistance=-0.1mm EdgesToMove=?.edge(at (21.7493, 10.9246, 0)))
  Magnet_1.move_edges(MoveAlongNormalFlag=true OffsetDistance=-0.1mm EdgesToMove=?.edge(at (28.5486, 5.96414, 0)))
  Magnet_1.move_edges(MoveAlongNormalFlag=true OffsetDistance=EdgeMove EdgesToMove=?.edge(at (32.3544, 1.70173, 0)))
  Magnet_1.move_edges(MoveAlongNormalFlag=true OffsetDistance=EdgeMove EdgesToMove=?.edge(at (26.8945, 3.46083, 0)))
  Magnet_1.move_edges(MoveAlongNormalFlag=true OffsetDistance=EdgeMove EdgesToMove=?.edge(at (23.104, 7.6542, 0)))
  Circle3 = circle(normal=Z, centre=(0mm, 0mm, 0mm), radius=58mm)
  Circle4 = circle(normal=Z, centre=(0mm, 0mm, 0mm), radius=56mm)
  Circle3.subtract(Circle4)
  Circle3.split(plane=ZX, keep=PositiveOnly)
  Circle3.rotate(axis=Z, angle=-135deg)
  Circle3.split(plane=ZX, keep=PositiveOnly)
  Stator_core_1_57_2.unite(Circle3)
  Stator1, Stator3 [M250_35A, non-model] = imported_body()
  Stator2 [M250_35A] = imported_body()
  Rotor [M250_35A, non-model] = imported_body()
  Region [vacuum] = polyline((0mm, 0mm, 0mm) (43.84062mm, 43.84062mm, 0mm))
  Polyline3 = polyline(z=0mm, xy in mm: (62, 0) (57.280531, 23.726373) (43.84062, 43.84062), AngularArc from point 0 over 3 centre=(0mm, 0mm, 0mm) angle=45deg plane=XY)
  Polyline4 = polyline((0mm, 0mm, 0mm) (62mm, 0mm, 0mm))
  Region.unite(Polyline3, Polyline4)
  Region.cover_lines()
  Rotor_1..Rotor_7 = Rotor.duplicate_around_axis(axis=Z, angle=45deg, total=8)
  Rotor.unite(Rotor_1..Rotor_7)
  Magnet_1_1 [N42SH, oriented by RelativeCS2], Magnet_1_2 [N42SH, oriented by RelativeCS3], Magnet_1_3 [N42SH, oriented by RelativeCS4], Magnet_1_4 [N42SH, oriented by RelativeCS5], Magnet_1_5 [N42SH, oriented by RelativeCS6], Magnet_1_6 [N42SH, oriented by RelativeCS7], Magnet_1_7 [N42SH, oriented by RelativeCS8] = Magnet_1.duplicate_around_axis(axis=Z, angle=45deg, total=8)
  coordinate_system RelativeCS2 = origin=(0mm, 0mm, 0mm) x=(cos(-pole_angle + theta_1 - 45deg), -sin(-pole_angle + theta_1 - 45deg), 0mm) y=(cos(-(pole_angle +90deg) + theta_1 - 45deg), -sin(-(pole_angle+90deg) + theta_1 - 45deg), 0mm)
  coordinate_system RelativeCS3 = origin=(0mm, 0mm, 0mm) x=(cos(-pole_angle + theta_1 - 90deg), -sin(-pole_angle + theta_1 - 90deg), 0mm) y=(cos(-(pole_angle+90deg) + theta_1 - 90deg), -sin(-(pole_angle+90deg) + theta_1 - 90deg), 0mm)
  coordinate_system RelativeCS4 = origin=(0mm, 0mm, 0mm) x=(cos(-pole_angle + theta_1 - 135deg), -sin(-pole_angle + theta_1 - 135deg), 0mm) y=(cos(-(pole_angle+90deg) + theta_1 - 135deg), -sin(-(pole_angle+90deg) + theta_1 - 135deg), 0mm)
  coordinate_system RelativeCS5 = origin=(0mm, 0mm, 0mm) x=(cos(-pole_angle + theta_1 - 180deg), -sin(-pole_angle + theta_1 - 180deg), 0mm) y=(cos(-(pole_angle+90deg) + theta_1 - 180deg), -sin(-(pole_angle+90deg) + theta_1 - 180deg), 0mm)
  coordinate_system RelativeCS6 = origin=(0mm, 0mm, 0mm) x=(cos(-pole_angle + theta_1 - 225deg), -sin(-pole_angle + theta_1 - 225deg), 0mm) y=(cos(-(pole_angle+90deg) + theta_1 - 225deg), -sin(-(pole_angle+90deg) + theta_1 - 225deg), 0mm)
  coordinate_system RelativeCS7 = origin=(0mm, 0mm, 0mm) x=(cos(-pole_angle + theta_1 - 270deg), -sin(-pole_angle + theta_1 - 270deg), 0mm) y=(cos(-(pole_angle+90deg) + theta_1 - 270deg), -sin(-(pole_angle+90deg) + theta_1 - 270deg), 0mm)
  coordinate_system RelativeCS8 = origin=(0mm, 0mm, 0mm) x=(cos(-pole_angle + theta_1 - 315deg), -sin(-pole_angle + theta_1 - 315deg), 0mm) y=(cos(-(pole_angle+90deg) + theta_1 - 315deg), -sin(-(pole_angle+90deg) + theta_1 - 315deg), 0mm)
  Magnet_2_1 [N42SH, oriented by RelativeCS16], Magnet_2_2 [N42SH, oriented by RelativeCS15], Magnet_2_3 [N42SH, oriented by RelativeCS14], Magnet_2_4 [N42SH, oriented by RelativeCS13], Magnet_2_5 [N42SH, oriented by RelativeCS12], Magnet_2_6 [N42SH, oriented by RelativeCS11], Magnet_2_7 [N42SH, oriented by RelativeCS10] = Magnet_2.duplicate_around_axis(axis=Z, angle=45deg, total=8)
  coordinate_system RelativeCS16 = origin=(0mm, 0mm, 0mm) x=(cos(-pole_angle + theta_2 + 315deg), -sin(-pole_angle + theta_2 + 315deg), 0mm) y=(cos(-(pole_angle+90deg) + theta_2 + 315deg), -sin(-(pole_angle+90deg) + theta_2 + 315deg), 0mm)
  coordinate_system RelativeCS15 = origin=(0mm, 0mm, 0mm) x=(cos(-pole_angle + theta_2 + 270deg), -sin(-pole_angle + theta_2 + 270deg), 0mm) y=(cos(-(pole_angle+90deg) + theta_2 + 270deg), -sin(-(pole_angle+90deg) + theta_2 + 270deg), 0mm)
  coordinate_system RelativeCS14 = origin=(0mm, 0mm, 0mm) x=(cos(-pole_angle + theta_2 + 225deg), -sin(-pole_angle + theta_2 + 225deg), 0mm) y=(cos(-(pole_angle+90deg) + theta_2 + 225deg), -sin(-(pole_angle+90deg) + theta_2 + 225deg), 0mm)
  coordinate_system RelativeCS13 = origin=(0mm, 0mm, 0mm) x=(cos(-pole_angle + theta_2 + 180deg), -sin(-pole_angle + theta_2 + 180deg), 0mm) y=(cos(-(pole_angle+90deg) + theta_2 + 180deg), -sin(-(pole_angle+90deg) + theta_2 + 180deg), 0mm)
  coordinate_system RelativeCS12 = origin=(0mm, 0mm, 0mm) x=(cos(-pole_angle + theta_2 + 135deg), -sin(-pole_angle + theta_2 + 135deg), 0mm) y=(cos(-(pole_angle+90deg) + theta_2 + 135deg), -sin(-(pole_angle+90deg) + theta_2 + 135deg), 0mm)
  coordinate_system RelativeCS11 = origin=(0mm, 0mm, 0mm) x=(cos(-pole_angle + theta_2 + 90deg), -sin(-pole_angle + theta_2 + 90deg), 0mm) y=(cos(-(pole_angle+90deg) + theta_2 + 90deg), -sin(-(pole_angle+90deg) + theta_2 + 90deg), 0mm)
  coordinate_system RelativeCS10 = origin=(0mm, 0mm, 0mm) x=(cos(-pole_angle + theta_2 + 45deg), -sin(-pole_angle + theta_2 + 45deg), 0mm) y=(cos(-(pole_angle+90deg) + theta_2 + 45deg), -sin(-(pole_angle+90deg) + theta_2 + 45deg), 0mm)
  [Magnet_1, Magnet_1_1..Magnet_1_7, Magnet_2, Magnet_2_1..Magnet_2_7, Rotor].rotate(axis=Z, angle=initAngle)
  [Magnet_1, Magnet_1_1..Magnet_1_7, Magnet_2, Magnet_2_1..Magnet_2_7, Rotor].rotate(axis=Z, angle=Pole_Angle)
  Rectangle1 = rectangle(corner=(-50mm, 0mm, 0mm), x_size=100mm, y_size=-40mm)
  coordinate_system RelativeCS_45deg = origin=(0mm, 0mm, 0mm) x=(1mm, 1mm, 0mm) y=(0mm, 1mm, 0mm)
  Rectangle2 = rectangle(corner=(-50mm, 0mm, 0mm), x_size=100mm, y_size=45mm) in RelativeCS_45deg
  Rectangle1_1 = Rectangle1.copy()
  Rectangle2_1 = Rectangle2.copy()
  Magnet_1.subtract(Rectangle1_1, Rectangle2_1)
  Rectangle1.unite(Rectangle2)
  Rectangle1_10 = Rectangle1.copy()
  Magnet_1.subtract(Rectangle1_10)
  Rectangle1_11 = Rectangle1.copy()
  Magnet_1.subtract(Rectangle1_11)
  Rectangle1_12 = Rectangle1.copy()
  Magnet_1_1.subtract(Rectangle1_12)
  Rectangle1_13 = Rectangle1.copy()
  Magnet_1_2.subtract(Rectangle1_13)
  Rectangle1_14 = Rectangle1.copy()
  Magnet_1_3.subtract(Rectangle1_14)
  Rectangle1_15 = Rectangle1.copy()
  Magnet_1_4.subtract(Rectangle1_15)
  Rectangle1_16 = Rectangle1.copy()
  Magnet_1_5.subtract(Rectangle1_16)
  Rectangle1_17 = Rectangle1.copy()
  Magnet_1_6.subtract(Rectangle1_17)
  Rectangle1_18 = Rectangle1.copy()
  Magnet_1_7.subtract(Rectangle1_18)
  Rectangle1_19 = Rectangle1.copy()
  Magnet_2.subtract(Rectangle1_19)
  Rectangle1_20 = Rectangle1.copy()
  Magnet_2_1.subtract(Rectangle1_20)
  Rectangle1_21 = Rectangle1.copy()
  Magnet_2_2.subtract(Rectangle1_21)
  Rectangle1_22 = Rectangle1.copy()
  Magnet_2_3.subtract(Rectangle1_22)
  Rectangle1_23 = Rectangle1.copy()
  Magnet_2_4.subtract(Rectangle1_23)
  Rectangle1_24 = Rectangle1.copy()
  Magnet_2_5.subtract(Rectangle1_24)
  Rectangle1_25 = Rectangle1.copy()
  Magnet_2_6.subtract(Rectangle1_25)
  Rectangle1_26 = Rectangle1.copy()
  Magnet_2_7.subtract(Rectangle1_26)
  Rotor.subtract(Rectangle1)
  RoundRotor [M250_35A] = circle(normal=Z, centre=(0mm, 0mm, 0mm), radius=34.96mm)
  RoundRotor.split(plane=ZX, keep=PositiveOnly)
  RoundRotor.rotate(axis=Z, angle=-45deg)
  RoundRotor.split(plane=ZX, keep=NegativeOnly)
  RoundRotor.rotate(axis=Z, angle=45deg)
boundaries and excitations:
  Balloon1: Balloon Edges=Region.edge(at (57.2805, 23.7264, 0))
  Independent1: Independent Edges=Region.edge(at (31, 0, 0))
  Dependent1: Dependent Edges=Region.edge(at (21.9203, 21.9203, 0)) Independent=Independent1 SameAsMaster=false
  CurrentDensity1: Current Density Objects=PhaseA_1 Value=CD*cos(phase_delay)
  CurrentDensity2: Current Density Objects=PhaseA_2 Value=CD*cos(phase_delay)
  CurrentDensity3: Current Density Objects=PhaseA_3 Value=CD*cos(phase_delay)
  CurrentDensity4: Current Density Objects=PhaseA_4 Value=CD*cos(phase_delay)
  CurrentDensity5: Current Density Objects=PhaseB_1 Value="1*CD*cos(phase_delay - 120deg)"
  CurrentDensity6: Current Density Objects=PhaseB_2 Value="1*CD*cos(phase_delay - 120deg)"
  CurrentDensity7: Current Density Objects=PhaseB_3 Value="1*CD*cos(phase_delay - 120deg)"
  CurrentDensity8: Current Density Objects=PhaseB_4 Value="1*CD*cos(phase_delay - 120deg)"
  CurrentDensity9: Current Density Objects=PhaseC_1 Value="-1*CD*cos(phase_delay - 240deg)"
  CurrentDensity10: Current Density Objects=PhaseC_2 Value="-1*CD*cos(phase_delay - 240deg)"
  CurrentDensity11: Current Density Objects=PhaseC_3 Value="-1*CD*cos(phase_delay - 240deg)"
  CurrentDensity12: Current Density Objects=PhaseC_4 Value="-1*CD*cos(phase_delay - 240deg)"
parameters:
  Torque_Rotor: Torque Coordinate_System=Global Is_Positive=true Objects=[Magnet_1_1..Magnet_1_6, Magnet_2_1..Magnet_2_6, Magnet_1_7, Magnet_2_7]
  Torque_StatorCore: Torque Coordinate_System=Global Is_Positive=true Objects=Stator2
  Torque_Stator: Torque Coordinate_System=Global Is_Positive=true Objects=[PhaseA_1..PhaseA_4, PhaseB_1..PhaseB_4, PhaseC_1..PhaseC_4, Stator2]
setups:
  Setup1: Magnetostatic MaximumPasses=10 MinimumPasses=2 MinimumConvergedPasses=1 PercentRefinement=30 PercentError=1 NonLinearResidual=0.0001
optimetrics:
  ParametricSetup1: Parametric Sim._Setups=[Setup1]
    sweep Pole_Angle: LIN 0deg 45deg 1deg
field plots:
  Flux_Lines1: A on Setup1 : LastAdaptive
  Mesh1: MeshPlots on Setup1 : LastAdaptive
reports:
  Torque Plot 1: Torque_Rotor.Torque, Torque_RotorCore.Torque, Torque_Stator.Torque, Torque_StatorCore.Torque vs Pole_Angle on Setup1 : LastAdaptive
